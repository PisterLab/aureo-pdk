; libInit.il

drLoadDrf("./aureo.drf")
load("./GDS3D/skill/icdGDS3D.il")
